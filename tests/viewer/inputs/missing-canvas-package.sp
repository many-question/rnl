* optional Canvas package
* @RNL(type="header") { @VERSION("0.3"); @USE-PACKAGE(name="analog-canvas-extensions", version="0.1") }
E1 b 0 a 0 2
* @RNL { #E1 @SET-SYMBOL $CANVAS_VCVS_DIAMOND; #E1 @PLACE(0, 0) }
.end
